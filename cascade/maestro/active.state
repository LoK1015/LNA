ADE simulation setup
Test HW2_cascade_1: HW2/cascade/schematic, simulator spectre
  Models: /dfs/app/tsmc_icdc/tsmc022/tsmc022_ULL/PDK/TN22CRSP004W1_1_3_1P1A/SkillPcell_RF_0p8_2p5_1P10M_6X3Z_UT-AlRDL_TaN/tsmcN22/../models/spectre/toplevel.scs[top_tt]
  Variables: Lx = 154p; Cd = 10f; Ls3 = 24.5p; Lg3 = 380p; Ls2 = 31.6p; Lg2 = 30p; Ld = 30.5p; Ibias = 540u; Vdd = 900m; Vac = 1; Cby = 5p; prf1 = -50; frf1 = 28G; M = 8; Nf = 20; W = 400n; Rx = 2*3.1412*Lx*28G/15; Rs = 2*3.1412*Ls3*28G/15; Rg = 2*3.1412*Lg3*28G/15; Rs2 = 2*3.1412*Ls2*28G/15; Rg2 = 2*3.1412*Lg2*28G/15; Rd = 2*3.1412*Ld*28G/15
  Temperature: 27
  Analysis sp: center=28G span=10G oprobe=/PORT1 iprobe=/PORT0 ports=("/PORT0" "/PORT1") donoise=yes
  Analysis dc: (saves the operating point)
  Output S11 mag = spm('sp 1 1) (unticked)
  Output S12 mag = spm('sp 1 2) (unticked)
  Output S21 mag = spm('sp 2 1) (unticked)
  Output S22 mag = spm('sp 2 2) (unticked)
  Output S11 dB20 = db(spm('sp 1 1))
  Output S12 dB20 = db(spm('sp 1 2))
  Output S21 dB20 = db(spm('sp 2 1))
  Output S22 dB20 = db(spm('sp 2 2))
  Output Kf = kf(sp(1 1 ?result "sp") sp(1 2 ?result "sp") sp(2 1 ?result "sp") sp(2 2 ?result "sp"))
  Output NF mag = getData("F" ?result "sp_noise") (unticked)
  Output NF dB10 = db10(getData("F" ?result "sp_noise"))
  Output delta = ((spm('sp 1 1) * spm('sp 2 2)) - (spm('sp 2 1) * spm('sp 1 2)))
Run mode: Single Run, Sweeps and Corners
