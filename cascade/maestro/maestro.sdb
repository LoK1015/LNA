ADE simulation setup
Run mode: Single Run, Sweeps and Corners
Tests:
  HW2_cascade_1: HW2/cascade/schematic, simulator spectre
    Variables: Lx = 154p; Rx = 2*3.1412*Lx*28G/15; Cd = 10f; Ls3 = 24.5p; Lg3 = 380p; Rs = 2*3.1412*Ls3*28G/15; Rg = 2*3.1412*Lg3*28G/15; Ls2 = 31.6p; Lg2 = 30p; Rs2 = 2*3.1412*Ls2*28G/15; Rg2 = 2*3.1412*Lg2*28G/15; Ld = 30.5p; Rd = 2*3.1412*Ld*28G/15; Ibias = 540u; Vdd = 900m; Vac = 1; Cby = 5p; prf1 = -50; frf1 = 28G; M = 8; Nf = 20; W = 400n
