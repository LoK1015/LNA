ADE simulation setup
Test HW2_test2_1: HW2/test2/schematic, simulator spectre
  Models: /dfs/app/tsmc_icdc/tsmc022/tsmc022_ULL/PDK/TN22CRSP004W1_1_3_1P1A/SkillPcell_RF_0p8_2p5_1P10M_6X3Z_UT-AlRDL_TaN/tsmcN22/../models/spectre/toplevel.scs[top_tt]
  Variables: Lx = 154p; Ls3 = 24.5p; Lg3 = 380p; Cd = 10f; Ls = 12.35p; Lg = 514.5p; Ld = 30.5p; Ibias = 540u; Vdd = 900m; Vac = 1; Cby = 5p; prf1 = -50; frf1 = 28G; Cold = 63.32f; M = 8; Nf = 20; W = 400n; Rx = 2*3.1412*Lx*28G/15; Cnew = Cd+Cold; Ld2 = Ld; Rs = 2*3.1412*Ls3*28G/15; Rg = 2*3.1412*Lg3*28G/15; Rd = 2*3.1412*Ld*28G/15; Ls2 = Ls*(Cnew/Cold); Lg2 = Lg*(Cold/Cnew)
  Temperature: 27
  Analysis pss: sweep prf1 start=-50 stop=20 lin=50 engine=Shooting fund=28G harms=1
  Analysis hb: sweep prf1 start=-50 stop=20 lin=70 fundfreqs=("(frf1)") funds=("rf1") maxharms=("3") tstab=auto errpreset=moderate
  Analysis sp: center=28G span=10G oprobe=/PORT1 iprobe=/PORT0 ports=("/PORT0" "/PORT1") donoise=yes
  Analysis hbac: start=28.8G maxsideband=2
  Analysis pac: start=28.8G fund=28G maxsideband=2
  Analysis dc: (saves the operating point)
  Analysis ac: center=28G span=10G
  Output S11 dB20 = db(spm('sp 1 1))
  Output S21 dB20 = db(spm('sp 2 1))
  Output S22 dB20 = db(spm('sp 2 2))
  Output S12 dB20 = db(spm('sp 1 2))
  Output ZM 2 reOhms = real(zm(2 ?result "sp")) (unticked)
  Output ZM 2 imOhms = imag(zm(2 ?result "sp")) (unticked)
  Output ZM 1 reOhms = real(zm(1 ?result "sp"))
  Output ZM 1 imOhms = imag(zm(1 ?result "sp"))
  Output Vgain = (vfreq('ac "/net8") / vfreq('ac "/net4"))
  Output NF dB10 = db10(getData("F" ?result "sp_noise"))
  Output NFmin dB10 = db10(getData("Fmin" ?result "sp_noise"))
  Output Kf = kf(sp(1 1 ?result "sp") sp(1 2 ?result "sp") sp(2 1 ?result "sp") sp(2 2 ?result "sp")) (unticked)
  Output S11 mag = spm('sp 1 1) (unticked)
  Output S22 mag = spm('sp 2 2) (unticked)
  Output S21 mag = spm('sp 2 1) (unticked)
  Output S12 mag = spm('sp 1 2) (unticked)
  Output Delta = ((spm('sp 1 1) * spm('sp 2 2)) - (spm('sp 2 1) * spm('sp 1 2))) (unticked)
  Output NC freq=2.8e+10 = nc(getData("Fmin" ?result "sp_noise") gmin(getData("Gopt" ?result "sp_noise") getData("Bopt" ?result "sp_noise") zref(1 ?result "sp")) getData("NNR" ?result "sp_noise") '(0.0 0.1 0.2 0.3 0.4 0.5 0.6 0.7 0.8 0.9 1.0 1.1 1.2 1.3 1.4 1.5 1.6 1.7 1.8 1.9 2.0 2.1 2.2 2.3 2.4 2.5 2.6 2.7 2.8 2.9 3.0) '2.8e+10) (unticked)
  Output GPC freq=2.8e+10 = gpc(sp(1 1 ?result "sp") sp(1 2 ?result "sp") sp(2 1 ?result "sp") sp(2 2 ?result "sp") '(10.0 10.1 10.2 10.3 10.4 10.5 10.6 10.7 10.8 10.9 11.0 11.1 11.2 11.3 11.4 11.5 11.6 11.7 11.8 11.9 12.0 12.1 12.2 12.3 12.4 12.5 12.6 12.7 12.8 12.9 13.0 13.1 13.2 13.3 13.4 13.5 13.6 13.7 13.8 13.9 14.0 14.1 14.2 14.3 14.4 14.5 14.6 14.7 14.8 14.9 15.0 15.1 15.2 15.3 15.4 15.5 15.6 15.7 15.8 15.9 16.0 16.1 16.2 16.3 16.4 16.5 16.6 16.7 16.8 16.9 17.0 17.1 17.2 17.3 17.4 17.5 17.6 17.7 17.8 17.9 18.0 18.1 18.2 18.3 18.4 18.5 18.6 18.7 18.8 18.9 19.0 19.1 19.2 19.3 19.4 19.5 19.6 19.7 19.8 19.9 20.0) '2.8e+10) (unticked)
Run mode: Single Run, Sweeps and Corners
