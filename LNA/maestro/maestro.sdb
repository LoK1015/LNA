ADE simulation setup
Run mode: Single Run, Sweeps and Corners
Tests:
  HW2_test2_1: HW2/test2/schematic, simulator spectre
    Variables: Lx = 154p; Rx = 2*3.1412*Lx*28G/15; Ls3 = 24.5p; Lg3 = 380p; Cnew = Cd+Cold; Cd = 10f; Ls2 = Ls*(Cnew/Cold); Lg2 = Lg*(Cold/Cnew); Ld2 = Ld; Ls = 12.35p; Lg = 514.5p; Ld = 30.5p; Rs = 2*3.1412*Ls3*28G/15; Rg = 2*3.1412*Lg3*28G/15; Rd = 2*3.1412*Ld*28G/15; Ibias = 540u; Vdd = 900m; Vac = 1; Cby = 5p; prf1 = -50; frf1 = 28G; Cold = 63.32f; M = 8; Nf = 20; W = 400n
